** Profile: "SCHEMATIC1-psf"  [ C:\Users\calin1q2w\Desktop\P1_2024_433A_Nuica_Mihai_Calin_PAI_N21_OrCAD\Schematics\p1\p1_2-pspicefiles\schematic1\psf.sim ]

** Creating circuit file "psf.cir"
** WARNING: THIS AUTOMATICALLY GENERATED FILE MAY BE OVERWRITTEN BY SUBSEQUENT SIMULATIONS

*Libraries:
* Profile Libraries :
* Local Libraries :
* From [PSPICE NETLIST] section of C:\Users\calin1q2w\AppData\Roaming\SPB_Data\cdssetup\OrCAD_PSpice\17.2.0\PSpice.ini file:
.lib "nomd.lib"

*Analysis directives:
.OPTIONS ADVCONV
.PROBE64 V(alias(*)) I(alias(*)) W(alias(*)) D(alias(*)) NOISE(alias(*))
.INC "..\SCHEMATIC1.net"

.END
